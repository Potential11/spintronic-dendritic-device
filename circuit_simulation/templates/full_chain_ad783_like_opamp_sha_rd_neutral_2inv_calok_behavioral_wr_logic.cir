* Full chain, revised per hand-drawn structure:
*   RD-enabled sample voltage source -> dual sample/hold -> op-amp difference
*   -> two TLV3501 comparators -> NOR + RD AND for Neutral.
*
* Previous versions are kept unchanged.
*
* Intentional simplification:
*   The first "sample" block in the drawing is ignored and represented by an
*   RD-enabled sample voltage source, as requested.
*
* Core implementation:
*   - Dual S/H: AD783-like SHA macro model with finite-bandwidth op-amp buffers
*   - Difference amplifier: genopa1 macro model with resistor network
*   - Comparators: two TLV3501 macro models
*   - Logic: transistor-level CMOS NOR and AND, no B-source logic

.title full_chain_ad783_like_opamp_sha_rd_neutral_2inv_calok_behavioral_wr_logic
.include AD783_like_SHA_opamp.lib
.include TLV3501.lib
.include ../basic_models/OpAmps/generic_opamp.lib

.param DB=50m
.param VCM=2.5

* Supplies
VDD_LOGIC vdd 0 5
VSS_LOGIC vss 0 0
VDD_SHA vcc_sha 0 5
VEE_SHA vee_sha 0 -5
VDD_DIFF vdd_diff 0 5
VEE_DIFF vee_diff 0 -5
VEN en 0 0

* Clocked control stimuli.
* WR1..WR5 are one-clock-high windows. RD follows each WR and has the same width.
VCLK clk 0 PWL(0 5 1u 5 1.005u 0 4u 0 4.005u 5 5u 5 5.005u 0 8u 0 8.005u 5 9u 5 9.005u 0 12u 0 12.005u 5 13u 5 13.005u 0 16u 0 16.005u 5 17u 5 17.005u 0 20u 0 20.005u 5 21u 5 21.005u 0 24u 0 24.005u 5 25u 5 25.005u 0 28u 0 28.005u 5 29u 5 29.005u 0 32u 0 32.005u 5 33u 5 33.005u 0 36u 0 36.005u 5 37u 5 37.005u 0 40u 0 40.005u 5 41u 5 41.005u 0 48u 0)
VWR1 wr1 0 PWL(0 5 1u 5 1.005u 0 48u 0)
VWR2 wr2 0 PWL(0 0 8u 0 8.005u 5 9u 5 9.005u 0 48u 0)
VWR3 wr3 0 PWL(0 0 16u 0 16.005u 5 17u 5 17.005u 0 48u 0)
VWR4 wr4 0 PWL(0 0 24u 0 24.005u 5 25u 5 25.005u 0 48u 0)
VWR5 wr5 0 PWL(0 0 32u 0 32.005u 5 33u 5 33.005u 0 48u 0)
VWR1P wr1p 0 PWL(0 5 1u 5 1.005u 0 48u 0)
VWR2P wr2p 0 PWL(0 0 8u 0 8.005u 5 9u 5 9.005u 0 48u 0)
VWR3P wr3p 0 PWL(0 0 16u 0 16.005u 5 17u 5 17.005u 0 48u 0)
VWR4P wr4p 0 PWL(0 0 24u 0 24.005u 5 25u 5 25.005u 0 48u 0)
VWR5P wr5p 0 PWL(0 0 32u 0 32.005u 5 33u 5 33.005u 0 48u 0)
VRD rd 0 PWL(0 0 4u 0 4.05u 5 5u 5 5.05u 0 12u 0 12.05u 5 13u 5 13.05u 0 20u 0 20.05u 5 21u 5 21.05u 0 28u 0 28.05u 5 29u 5 29.05u 0 36u 0 36.05u 5 37u 5 37.05u 0 48u 0)
VRDB rd_b 0 PWL(0 5 4u 5 4.05u 0 5u 0 5.05u 5 12u 5 12.05u 0 13u 0 13.05u 5 20u 5 20.05u 0 21u 0 21.05u 5 28u 5 28.05u 0 29u 0 29.05u 5 36u 5 36.05u 0 37u 0 37.05u 5 48u 5)
VINIT init 0 PWL(0 5 0.5u 5 0.505u 0 48u 0)

* Pure behavioral WR state registers for this functional demonstration.
* Each state changes at the corresponding WR rising edge and then remains
* stored without an analog hold capacitor.
VLOGIC_A coeff_a 0 PWL(0 0.10 8u 0.10 8.005u 0.25 16u 0.25 16.005u 0.50 24u 0.50 24.005u 0.75 32u 0.75 32.005u 1.00 48u 1.00)
VLOGIC_B coeff_b 0 PWL(0 0.10 8u 0.10 8.005u 0.25 16u 0.25 16.005u 0.50 24u 0.50 24.005u 0.75 32u 0.75 32.005u 1.00 48u 1.00)

* Pure numerical coefficient sum and RD-controlled voltage source.
B_COEFF_TOTAL coeff_total 0 V=V(coeff_a)+V(coeff_b)
B_RD_VOUT vout 0 V=V(coeff_total)*V(rd)/5
CVOUT_LOAD vout 0 1p

* Dual sample/hold: current sample follows Vout during RD, previous follows current during RD_B.
RINJ vout vout_sha 10
CIN vout_sha 0 0.5p
XSH_CUR vout_sha rd 0 vee_sha v_cur vcc_sha AD783_LIKE_SHA_OPAMP
RLOAD_CUR v_cur 0 1Meg
XSH_PREV v_cur rd_b 0 vee_sha v_prev vcc_sha AD783_LIKE_SHA_OPAMP
RLOAD_PREV v_prev 0 1Meg

* Difference amplifier: vdiff ~= v_cur - v_prev.
* The output is level-shifted to keep the single-supply TLV3501 inputs valid:
* vdiff ~= VCM + v_cur - v_prev.
VCM_REF vcm 0 {VCM}
RDIFF1 v_prev nminus 10k
RDIFF2 vdiff  nminus 10k
RDIFF3 v_cur  nplus  10k
RDIFF4 nplus  vcm    10k
XDIFF nplus nminus vdd_diff vee_diff vdiff genopa1 params: GAIN=100k POLE=10e6 ROUT=10 VOFF=0
RDIFF_LOAD vdiff 0 1Meg
CDIFF_LOAD vdiff 0 2p

* Fixed VCM +/- DB references for the final window comparators.
VDBP dbp 0 {VCM + DB}
VDBN dbn 0 {VCM - DB}

* Two TLV3501 comparators.
* Right: vdiff > VCM + DB. Left: vdiff < VCM - DB.
* The comparator outputs are the public Right/Left outputs directly.
XU_RIGHT vdiff dbp   vdd vss right en TLV3501
XU_LEFT  dbn   vdiff vdd vss left  en TLV3501
RRIGHT_LOAD right 0 10k
RLEFT_LOAD  left  0 10k
CRIGHT_LOAD right 0 22p
CLEFT_LOAD  left  0 22p

* Transistor-level CMOS logic.
.model NMOS_LOGIC NMOS LEVEL=1 VTO=1.2 KP=500u LAMBDA=0.02
.model PMOS_LOGIC PMOS LEVEL=1 VTO=-1.2 KP=250u LAMBDA=0.02
.model DLOGIC_CLAMP D IS=1e-6 RS=0.1 N=1

DRIGHT_H right vdd DLOGIC_CLAMP
DRIGHT_L 0 right DLOGIC_CLAMP

DLEFT_H left vdd DLOGIC_CLAMP
DLEFT_L 0 left DLOGIC_CLAMP

* Neutral = RD-delayed AND NOR(right, left)
* RD is delayed only for the Neutral gate by two transistor-level CMOS
* inverters. Two inversions keep the same polarity as RD while replacing the
* previous RC delay element.
*
* The second inverter is intentionally skewed: weak PMOS and strong NMOS.
* That gives rd_neutral a delayed rising edge but a fast falling edge, avoiding
* the trailing-edge Neutral hazard that a symmetric two-inverter delay creates.
MP_RD_INV1 rd_neutral_n rd vdd vdd PMOS_LOGIC W=80u L=1u
MN_RD_INV1 rd_neutral_n rd 0   0   NMOS_LOGIC W=40u L=1u
CRD_INV1 rd_neutral_n 0 10p
DRD_INV1_H rd_neutral_n vdd DLOGIC_CLAMP
DRD_INV1_L 0 rd_neutral_n DLOGIC_CLAMP

MP_RD_INV2 rd_neutral rd_neutral_n vdd vdd PMOS_LOGIC W=1u L=1u
MN_RD_INV2 rd_neutral rd_neutral_n 0   0   NMOS_LOGIC W=80u L=1u
CRD_INV2 rd_neutral 0 47p
DRD_INV2_H rd_neutral vdd DLOGIC_CLAMP
DRD_INV2_L 0 rd_neutral DLOGIC_CLAMP

* CAL_OK generation.
* init resets CAL_OK low. The first RD falling edge produces rd_end, which
* sets CAL_OK high, so the first RD after init is used only for calibration.
MP_RD_FAST_N rd_fast_n rd vdd vdd PMOS_LOGIC W=40u L=1u
MN_RD_FAST_N rd_fast_n rd 0   0   NMOS_LOGIC W=40u L=1u
CRD_FAST_N rd_fast_n 0 2p
DRD_FAST_N_H rd_fast_n vdd DLOGIC_CLAMP
DRD_FAST_N_L 0 rd_fast_n DLOGIC_CLAMP

MP_RD_DLY1 rd_edge_n rd vdd vdd PMOS_LOGIC W=20u L=1u
MN_RD_DLY1 rd_edge_n rd 0   0   NMOS_LOGIC W=20u L=1u
CRD_EDGE_N rd_edge_n 0 6p
DRD_EDGE_N_H rd_edge_n vdd DLOGIC_CLAMP
DRD_EDGE_N_L 0 rd_edge_n DLOGIC_CLAMP

MP_RD_DLY2 rd_delay rd_edge_n vdd vdd PMOS_LOGIC W=20u L=1u
MN_RD_DLY2 rd_delay rd_edge_n 0   0   NMOS_LOGIC W=20u L=1u
CRD_DELAY rd_delay 0 6p
DRD_DELAY_H rd_delay vdd DLOGIC_CLAMP
DRD_DELAY_L 0 rd_delay DLOGIC_CLAMP

* rd_end = rd_delay AND rd_fast_n.
MP_RD_END_NAND1 rd_end_n rd_delay  vdd vdd PMOS_LOGIC W=20u L=1u
MP_RD_END_NAND2 rd_end_n rd_fast_n vdd vdd PMOS_LOGIC W=20u L=1u
MN_RD_END_NAND1 rd_end_n rd_delay  rd_end_mid 0 NMOS_LOGIC W=20u L=1u
MN_RD_END_NAND2 rd_end_mid rd_fast_n 0          0 NMOS_LOGIC W=20u L=1u
MP_RD_END_INV rd_end rd_end_n vdd vdd PMOS_LOGIC W=20u L=1u
MN_RD_END_INV rd_end rd_end_n 0   0   NMOS_LOGIC W=20u L=1u
CRD_END rd_end 0 4p
DRD_END_H rd_end vdd DLOGIC_CLAMP
DRD_END_L 0 rd_end DLOGIC_CLAMP

* Cross-coupled CMOS NOR SR latch:
*   SET=rd_end, RESET=init, Q=cal_ok, Qbar=cal_ok_n.
MP_CAL_Q_A cal_q_pser init vdd vdd PMOS_LOGIC W=40u L=1u
MP_CAL_Q_B cal_ok cal_ok_n cal_q_pser vdd PMOS_LOGIC W=40u L=1u
MN_CAL_Q_A cal_ok init     0 0 NMOS_LOGIC W=20u L=1u
MN_CAL_Q_B cal_ok cal_ok_n 0 0 NMOS_LOGIC W=20u L=1u

MP_CAL_QN_A cal_qn_pser rd_end vdd vdd PMOS_LOGIC W=40u L=1u
MP_CAL_QN_B cal_ok_n cal_ok cal_qn_pser vdd PMOS_LOGIC W=40u L=1u
MN_CAL_QN_A cal_ok_n rd_end 0 0 NMOS_LOGIC W=20u L=1u
MN_CAL_QN_B cal_ok_n cal_ok  0 0 NMOS_LOGIC W=20u L=1u
CCAL_OK cal_ok 0 10p
CCAL_OK_N cal_ok_n 0 10p
DCAL_OK_H cal_ok vdd DLOGIC_CLAMP
DCAL_OK_L 0 cal_ok DLOGIC_CLAMP
DCAL_OK_N_H cal_ok_n vdd DLOGIC_CLAMP
DCAL_OK_N_L 0 cal_ok_n DLOGIC_CLAMP

* CMOS NOR.
MP_NOR1 n_pser right vdd    vdd PMOS_LOGIC W=40u L=1u
MP_NOR2 n_nor  left  n_pser vdd PMOS_LOGIC W=40u L=1u
MN_NOR1 n_nor  right 0      0   NMOS_LOGIC W=20u L=1u
MN_NOR2 n_nor  left  0      0   NMOS_LOGIC W=20u L=1u

* CMOS AND with delayed RD and CAL_OK: 3-input NAND then inverter.
MP_NAND1 n_neutral_nand rd_neutral vdd vdd PMOS_LOGIC W=20u L=1u
MP_NAND2 n_neutral_nand n_nor vdd vdd PMOS_LOGIC W=20u L=1u
MP_NAND3 n_neutral_nand cal_ok vdd vdd PMOS_LOGIC W=20u L=1u
MN_NAND1 n_neutral_nand rd_neutral n_neutral_mid 0 NMOS_LOGIC W=20u L=1u
MN_NAND2 n_neutral_mid  n_nor n_neutral_mid2 0 NMOS_LOGIC W=20u L=1u
MN_NAND3 n_neutral_mid2 cal_ok 0             0 NMOS_LOGIC W=20u L=1u
MP_NEUTRAL_INV neutral n_neutral_nand vdd vdd PMOS_LOGIC W=20u L=1u
MN_NEUTRAL_INV neutral n_neutral_nand 0   0   NMOS_LOGIC W=20u L=1u
CNEUTRAL neutral 0 22p
DNEUTRAL_H neutral vdd DLOGIC_CLAMP
DNEUTRAL_L 0 neutral DLOGIC_CLAMP

* Optional gated direction outputs for observing the same CAL_OK mask on
* right/left. Raw comparator nodes remain right and left.
MP_RIGHT_NAND1 n_right_valid_n right vdd vdd PMOS_LOGIC W=20u L=1u
MP_RIGHT_NAND2 n_right_valid_n rd_neutral vdd vdd PMOS_LOGIC W=20u L=1u
MP_RIGHT_NAND3 n_right_valid_n cal_ok vdd vdd PMOS_LOGIC W=20u L=1u
MN_RIGHT_NAND1 n_right_valid_n right n_right_mid 0 NMOS_LOGIC W=20u L=1u
MN_RIGHT_NAND2 n_right_mid rd_neutral n_right_mid2 0 NMOS_LOGIC W=20u L=1u
MN_RIGHT_NAND3 n_right_mid2 cal_ok 0 0 NMOS_LOGIC W=20u L=1u
MP_RIGHT_VALID_INV right_valid n_right_valid_n vdd vdd PMOS_LOGIC W=20u L=1u
MN_RIGHT_VALID_INV right_valid n_right_valid_n 0   0   NMOS_LOGIC W=20u L=1u
CRIGHT_VALID right_valid 0 12p
DRIGHT_VALID_H right_valid vdd DLOGIC_CLAMP
DRIGHT_VALID_L 0 right_valid DLOGIC_CLAMP

MP_LEFT_NAND1 n_left_valid_n left vdd vdd PMOS_LOGIC W=20u L=1u
MP_LEFT_NAND2 n_left_valid_n rd_neutral vdd vdd PMOS_LOGIC W=20u L=1u
MP_LEFT_NAND3 n_left_valid_n cal_ok vdd vdd PMOS_LOGIC W=20u L=1u
MN_LEFT_NAND1 n_left_valid_n left n_left_mid 0 NMOS_LOGIC W=20u L=1u
MN_LEFT_NAND2 n_left_mid rd_neutral n_left_mid2 0 NMOS_LOGIC W=20u L=1u
MN_LEFT_NAND3 n_left_mid2 cal_ok 0 0 NMOS_LOGIC W=20u L=1u
MP_LEFT_VALID_INV left_valid n_left_valid_n vdd vdd PMOS_LOGIC W=20u L=1u
MN_LEFT_VALID_INV left_valid n_left_valid_n 0   0   NMOS_LOGIC W=20u L=1u
CLEFT_VALID left_valid 0 12p
DLEFT_VALID_H left_valid vdd DLOGIC_CLAMP
DLEFT_VALID_L 0 left_valid DLOGIC_CLAMP

.tran 2n 48u
.control
set filetype=ascii
set wr_singlescale
run
wrdata full_chain_ad783_like_opamp_sha_rd_neutral_2inv_calok_behavioral_wr_logic.csv time v(clk) v(wr1) v(wr2) v(wr3) v(wr4) v(wr5) v(wr1p) v(wr2p) v(wr3p) v(wr4p) v(wr5p) v(coeff_a) v(coeff_b) v(coeff_total) v(init) v(rd) v(rd_fast_n) v(rd_delay) v(rd_end) v(cal_ok) v(rd_neutral_n) v(rd_neutral) v(vout) v(v_cur) v(v_prev) v(vdiff) v(right) v(left) v(right_valid) v(left_valid) v(neutral)
quit
.endc
.end
